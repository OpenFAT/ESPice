// bsource: ngspice's B element (ASRC, asrc/asrcload.c). V(p,n) (or, with
// BSRC_CURRENT defined, I(p,n) with no branch, as ngspice makes none
// (asrcset.c:81-88); with BSRC_CHARGE, the charge whose ddt is I(p,n),
// behind a behavioural VCCAP) equals an arbitrary
// expression of node voltages, branch currents, time and temperature. The frontend compiles the card's expression
// into a postfix tape held in the op_code/op_a/op_b/consts parameter arrays
// (src/frontend/builder.zig compileTape); this module interprets it, and
// VerA's forward-mode AD supplies the Jacobian through the runtime-indexed
// stack, in place of ngspice's symbolic derivative trees.
//
// Control ports c0..c7 are the distinct probed nets; unused ones are tied to
// ground by the host. A control port may also be wired to a branch-current
// row, so V(ck) then reads that current (the i() probe).
//
// Opcodes (keep in step with the builder's tape.Code):
//   0 num  push consts[a]        1 v    push V(c[a])      2 vd  push V(c[a])-V(c[b])
//   3 neg  4 not  5 add  6 sub  7 mul  8 div  9 powi (a = exponent)
//  10 powc (a = const index of the exponent)  11 pow  12 lt  13 gt  14 le
//  15 ge  16 eq  17 ne  18 and  19 or  20 sel  21 sqrt  22 abs  23 min  24 max
//  25 exp 26 ln  27 log10  28 sin  29 cos  30 tan  31 atan  32 tanh  33 floor
//  34 ceil  35 time  36 temper  37 pwl (a = const index of the table, b = its
//  point count; see below)
//
// Expression semantics:
// - powi multiplies its base repeatedly. For ngspice's default |x|^k
//   semantics, the frontend inserts abs before this optimization; HSPICE's
//   signed integer power uses it directly.
// - sqrt/log of a negative argument and exp overflow follow IEEE (NaN/inf,
//   caught by the solver's finiteness check) instead of ptfuncs.c's HUGE
//   substitute. log(0) is PTlog's -1e99, finite, so Newton recovers from a
//   0 V start. Division follows ngspice (PTdivide's 1e-32).
// - min, max and abs keep ngspice's tie rules: a tie goes to a, abs keeps -0.
//
// Temperature (asrcload.c): the value is scaled by 1 + tc1*dT + tc2*dT^2,
// dT = (T + dtemp) - 300.15 K, inverted when reciproctc != 0.
`include "disciplines.vams"
`include "constants.vams"

`ifdef BSRC_CHARGE
module bsource_q(p, n, c0, c1, c2, c3, c4, c5, c6, c7);
`elsif BSRC_CURRENT
module bsource_i(p, n, c0, c1, c2, c3, c4, c5, c6, c7);
`else
module bsource(p, n, c0, c1, c2, c3, c4, c5, c6, c7);
`endif
    inout p, n, c0, c1, c2, c3, c4, c5, c6, c7;
    electrical p, n, c0, c1, c2, c3, c4, c5, c6, c7;
    branch (p, n) br;

    parameter real tc1 = 0.0;
    parameter real tc2 = 0.0;
    parameter real dtemp = 0.0;
    // Device temperature in K; <= 0 means the circuit temperature.
    parameter real temp = -1.0e3;
    parameter integer reciproctc = 0;
    parameter integer n_ops = 0 from [0:64];
    parameter integer op_code[0:63] = '{64{0}};
    parameter integer op_a[0:63] = '{64{0}};
    parameter integer op_b[0:63] = '{64{0}};
    parameter real consts[0:31] = '{32{0.0}};

    analog begin : tape
        // Per-evaluation scratch, never held state (VAMS variables are
        // static; VerA's vera_scratch starts them at 0 on every evaluation).
        // st skips that zeroing ("uninit"): only a push raises sp, and a push
        // writes st[sp], so every read below sp reads a written slot, and the
        // final read is guarded by sp <= 0 (a malformed tape that pops past
        // the bottom). The 1152-byte memset was 3.5% of a B-source-heavy run.
        (* vera_scratch *) real vc[0:7];
        (* vera_scratch = "uninit" *) real st[0:15];
        real a, b, r, f, tdev, dt, factor;
        integer k, sp, j, np, at;
        real d, xi, yi, lower, upper, seg_lo, seg_hi, u, w;
        vc[0] = V(c0); vc[1] = V(c1); vc[2] = V(c2); vc[3] = V(c3);
        vc[4] = V(c4); vc[5] = V(c5); vc[6] = V(c6); vc[7] = V(c7);
        sp = 0;
        for (k = 0; k < n_ops; k = k + 1) begin
            case (op_code[k])
                0: begin st[sp] = consts[op_a[k]]; sp = sp + 1; end
                1: begin st[sp] = vc[op_a[k]]; sp = sp + 1; end
                2: begin st[sp] = vc[op_a[k]] - vc[op_b[k]]; sp = sp + 1; end
                35: begin st[sp] = $abstime; sp = sp + 1; end
                36: begin st[sp] = $temperature - `P_CELSIUS0; sp = sp + 1; end
                20: begin
                    sp = sp - 2;
                    if (st[sp - 1] != 0.0) st[sp - 1] = st[sp]; else st[sp - 1] = st[sp + 1];
                end
                5, 6, 7, 8, 11, 12, 13, 14, 15, 16, 17, 18, 19, 23, 24: begin
                    sp = sp - 1;
                    a = st[sp - 1];
                    b = st[sp];
                    case (op_code[k])
                        5: r = a + b;
                        6: r = a - b;
                        7: r = a * b;
                        // ptfuncs.c PTdivide: the divisor moves 1e-32 away
                        // from zero, so 0/0 at an all-zero start is 0.
                        8: r = a / (b + ((b >= 0.0) ? 1e-32 : -1e-32));
                        // pow handles 0^0 at Newton's all-zero start; the
                        // equivalent exp(b*ln(abs(a))) produces a NaN there.
                        11: r = pow((a < 0.0) ? -a : a, b);
                        12: r = (a < b) ? 1.0 : 0.0;
                        13: r = (b < a) ? 1.0 : 0.0;
                        14: r = (a <= b) ? 1.0 : 0.0;
                        15: r = (b <= a) ? 1.0 : 0.0;
                        16: r = (a == b) ? 1.0 : 0.0;
                        17: r = (a == b) ? 0.0 : 1.0;
                        18: r = (a != 0.0 && b != 0.0) ? 1.0 : 0.0;
                        19: r = (a != 0.0 || b != 0.0) ? 1.0 : 0.0;
                        23: if (a <= b) r = a; else r = b;
                        default: if (b <= a) r = a; else r = b;
                    endcase
                    st[sp - 1] = r;
                end
                default: begin
                    a = st[sp - 1];
                    case (op_code[k])
                        3: r = -a;
                        4: r = (a == 0.0) ? 1.0 : 0.0;
                        // x*(x*(x*...)): the base multiplies the running power.
                        9: begin
                            if (op_a[k] == 0) r = 1.0;
                            else begin
                                r = a;
                                for (j = 1; j < op_a[k]; j = j + 1) r = a * r;
                            end
                        end
                        10: r = pow((a < 0.0) ? -a : a, consts[op_a[k]]);
                        21: r = sqrt(a);
                        22: if (a < 0.0) r = -a; else r = a;
                        25: r = exp(a);
                        // ln(0) is ptfuncs.c PTlog's -1e99, so a Newton
                        // start at 0 V recovers (#77).
                        26: r = (a == 0.0) ? -1e99 : ln(a);
                        27: r = (a == 0.0) ? -1e99 : ln(a) * 0.4342944819032518;
                        28: r = sin(a);
                        29: r = cos(a);
                        30: r = sin(a) / cos(a);
                        31: r = atan(a);
                        32: r = tanh(a);
                        33: r = floor(a);
                        34: r = ceil(a);
                        // A smoothed piecewise-linear transfer through the
                        // table at consts[a]: the corner width, then op_b[k]
                        // (x, y) pairs, x ascending. The ends hold their y.
                        // Each corner is a parabola over |x - x_i| < d_i
                        // (XSPICE cm_smooth_corner): d_i = width times the
                        // shorter neighbouring segment for width > 0
                        // (ngspice TABLE: cm_pwl, input_domain = 0.1), or
                        // -width for width < 0 (HSPICE PWL(1) DELTA). The
                        // corner is picked at the midpoints, as cm_pwl does.
                        default: begin
                            at = op_a[k];
                            np = op_b[k];
                            j = 0;
                            while (j + 1 < np && a >= 0.5 * (consts[at + 1 + 2 * j] + consts[at + 3 + 2 * j])) j = j + 1;
                            xi = consts[at + 1 + 2 * j];
                            yi = consts[at + 2 + 2 * j];
                            if (j == 0) lower = 0.0;
                            else lower = (yi - consts[at + 2 * j]) / (xi - consts[at + 2 * j - 1]);
                            if (j + 1 == np) upper = 0.0;
                            else upper = (consts[at + 4 + 2 * j] - yi) / (consts[at + 3 + 2 * j] - xi);
                            // The virtual end points mirror the neighbouring segment.
                            if (j == 0) seg_lo = consts[at + 3] - xi;
                            else seg_lo = xi - consts[at + 2 * j - 1];
                            if (j + 1 == np) seg_hi = seg_lo;
                            else seg_hi = consts[at + 3 + 2 * j] - xi;
                            if (consts[at] > 0.0) d = consts[at] * min(seg_lo, seg_hi);
                            else d = -consts[at];
                            u = a - xi;
                            if (u < -d) r = yi + lower * u;
                            else if (u >= d) r = yi + upper * u;
                            else begin
                                // y = y_i + upper*u + (upper - lower)/(4d) * (u - d)^2.
                                w = u - d;
                                r = yi + upper * u + (upper - lower) / (4.0 * d) * w * w;
                            end
                        end
                    endcase
                    st[sp - 1] = r;
                end
            endcase
        end
        f = (sp <= 0) ? 0.0 : st[0];
        tdev = (temp <= 0.0) ? $temperature : temp;
        dt = (tdev + dtemp) - 300.15;
        factor = 1.0 + tc1 * dt + tc2 * dt * dt;
        if (reciproctc != 0) factor = 1.0 / factor;
`ifdef BSRC_CHARGE
        I(br) <+ ddt(f * factor);
`elsif BSRC_CURRENT
        I(br) <+ f * factor;
`else
        V(br) <+ f * factor;
`endif
    end
endmodule
